addrmap uart {
    reg {
        name = "UART control";
        field {
            sw = rw;
            hw = r;
            reset = 0x0;
        } enable[0:0];
    } ctrl @ 0x0;

    reg {
        name = "UART status";
        field {
            sw = r;
            hw = w;
        } busy[0:0];
    } status @ 0x4;
};
